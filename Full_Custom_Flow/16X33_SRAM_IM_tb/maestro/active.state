ADE simulation setup
Test ECE_224A_final_16X33_SRAM_IM_tb_1: ECE_224A_final/16X33_SRAM_IM_tb/schematic, simulator hspiceD
  Models: /fs/student/oindrila_chatterjee/ECE_224A/ncsu45_cp/hspice_nom.include
  Variables: vddi = 1
  Initial conditions: /out_sa<6> = 0; /blb<0:32> = 0; /bl<0:32> = vddi; /I5/I4293/Q = vddi; /I5/I4293/Qb = 0
  Analysis tran: start=0 stop=200n step=10p
  Signals: /pchb, /wl<0:15>, /bl<0:32>, /blb<0:32>, /sa_en, /out_sa<0:32>, /I5/I32/Q, /I5/I32/Qb, /addr<3:0>, /addr_en, /ck
