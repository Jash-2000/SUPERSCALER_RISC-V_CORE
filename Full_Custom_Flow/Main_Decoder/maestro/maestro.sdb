ADE simulation setup
Run mode: Single Run, Sweeps and Corners
Tests:
  Full_Custom_Flow_Main_Decoder_1: Full_Custom_Flow/Main_Decoder/schematic, simulator hspiceD
    Outputs: /I0/I4/I1/jash
