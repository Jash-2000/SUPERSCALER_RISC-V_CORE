ADE simulation setup
Test ECE_224A_final_SRAM_WLDEC_tb_1: ECE_224A_final/SRAM_WLDEC_tb/schematic, simulator hspiceD
  Models: /fs/student/oindrila_chatterjee/ECE_224A/ncsu45_cp/hspice_nom.include
  Variables: vddi = 1
  Analysis tran: start=0 stop=100n step=10p
  Signals: /ck, /addr_en, /wl<0:63>, /addr<5:0>
