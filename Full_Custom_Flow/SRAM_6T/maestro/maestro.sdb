ADE simulation setup
Run mode: Single Run, Sweeps and Corners
Tests:
  ECE_224A_REF_SRAM_6T_1: ECE_224A_REF/SRAM_6T/schematic, simulator hspiceD
    Variables: wn = {From/To}Linear:90n:30n:270n{From/To}
    Outputs: /BL; /BLB; /Q; /Qb
