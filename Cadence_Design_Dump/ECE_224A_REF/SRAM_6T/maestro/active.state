ADE simulation setup
Test ECE_224A_REF_SRAM_6T_1: ECE_224A_REF/SRAM_6T/schematic, simulator hspiceD
  Models: /fs/student/oindrila_chatterjee/ECE_224A/ncsu45_cp/hspice_nom.include
  Variables: wn = {From/To}Linear:90n:30n:270n{From/To}
  Analysis tran: start=0 stop=40n step=10p
  Signals: /BL, /BLB, /Q, /Qb
