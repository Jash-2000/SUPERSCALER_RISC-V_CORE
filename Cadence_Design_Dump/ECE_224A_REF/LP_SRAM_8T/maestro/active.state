ADE simulation setup
Test ECE_224A_REF_LP_SRAM_8T_1: ECE_224A_REF/LP_SRAM_8T/schematic, simulator hspiceD
  Models: /fs/student/oindrila_chatterjee/ECE_224A/ncsu45_cp/hspice_nom.include
  Variables: wp = 90n; Q = 1
  Analysis dc: sweep Q start=0 stop=1.8
  Signals: /Q, /Qb
