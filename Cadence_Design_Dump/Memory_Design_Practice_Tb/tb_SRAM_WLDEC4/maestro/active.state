ADE simulation setup
Test ECE_224A_REF_tb_tb_SRAM_DEC4_1: ECE_224A_REF_tb/tb_SRAM_WLDEC4/schematic, simulator hspiceD
  Models: /fs/student/oindrila_chatterjee/ECE_224A/ncsu45_cp/hspice_nom.include
  Variables: vddi = 1
  Analysis tran: start=0 stop=100n step=10p
  Signals: /addr<0>, /addr<1>, /ck, /addr_en, /wl<0:3>
