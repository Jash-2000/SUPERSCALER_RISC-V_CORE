ADE simulation setup
Test ECE_224A_REF_tb_tb_SRAM_READ_1: ECE_224A_REF_tb/tb_SRAM_READ/schematic, simulator hspiceD
  Models: /fs/student/oindrila_chatterjee/ECE_224A/ncsu45_cp/hspice_nom.include
  Variables: vddi = 1
  Initial conditions: /I2/Q = vddi; /I2/Qb = 0; /out_sa = 0
  Analysis tran: start=0 stop=40n step=10p
  Signals: /pchb, /wl, /bl, /blb, /sae, /out_sa, /I2/Q, /I2/Qb
Run mode: Single Run, Sweeps and Corners
