ADE simulation setup
Run mode: Single Run, Sweeps and Corners
Tests:
  ECE_224A_REF_tb_tb_SRAM_READ_1: ECE_224A_REF_tb/tb_SRAM_READ/schematic, simulator hspiceD
    Variables: vddi = 1
    Outputs: /pchb; /wl; /bl; /blb; /sae; /out_sa; /I2/Q; /I2/Qb
