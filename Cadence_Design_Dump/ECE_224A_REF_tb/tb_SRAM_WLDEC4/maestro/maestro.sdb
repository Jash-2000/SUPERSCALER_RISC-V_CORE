ADE simulation setup
Run mode: Single Run, Sweeps and Corners
Tests:
  ECE_224A_REF_tb_tb_SRAM_DEC4_1: ECE_224A_REF_tb/tb_SRAM_WLDEC4/schematic, simulator hspiceD
    Variables: vddi = 1
    Outputs: /addr<0>; /addr<1>; /ck; /addr_en; /wl<0:3>
