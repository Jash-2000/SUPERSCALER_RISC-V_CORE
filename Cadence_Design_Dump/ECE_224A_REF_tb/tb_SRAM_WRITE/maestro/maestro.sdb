ADE simulation setup
Run mode: Single Run, Sweeps and Corners
Tests:
  ECE_224A_REF_tb_tb_SRAM_WRITE_1: ECE_224A_REF_tb/tb_SRAM_WRITE/schematic, simulator hspiceD
    Variables: vddi = 1
    Outputs: /wr_en; /wr_di; /bl; /blb; /wl; /I6/Q; /I6/Qb
