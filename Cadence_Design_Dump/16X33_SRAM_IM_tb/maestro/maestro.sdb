ADE simulation setup
Run mode: Single Run, Sweeps and Corners
Tests:
  ECE_224A_final_16X33_SRAM_IM_tb_1: ECE_224A_final/16X33_SRAM_IM_tb/schematic, simulator hspiceD
    Variables: vddi = 1
    Outputs: /wr_di<32>; /vss; /wr_di<31>; /wr_di<30>; /wr_di<29>; /wr_di<28>; /wr_di<27>; /wr_di<26>; /wr_di<25>; /wr_di<24>; /wr_di<23>; /wr_di<22>; /wr_di<21>; /wr_di<20>; /wr_di<19>; /wr_di<18>; /wr_di<17>; /wr_di<16>; /wr_di<15>; /wr_di<14>; /wr_di<13>; /wr_di<12>; /wr_di<11>; /wr_di<10>; /wr_di<9>; /wr_di<8>; /wr_di<7>; /wr_di<6>; /wr_di<5>; /wr_di<4>; /wr_di<3>; /wr_di<2>; /wr_di<1>; /wr_di<0>; /pchb; /wl<2>; /bl<0>; /blb<0>; /sa_en; /out_sa<0>; /I5/I32/Q; /I5/I32/Qb; /addr<3:0>; /addr_en; /I1/CK; /ck; /wl<0:15>; /bl<0:32>; /blb<0:32>; /out_sa<0:32>
