ADE simulation setup
Run mode: Single Run, Sweeps and Corners
Tests:
  Test_INV_1: Test/INV/schematic, simulator hspiceD
    Variables: Q_dc = 0
