ADE simulation setup
Run mode: Single Run, Sweeps and Corners
Tests:
  ECE_224A_final_SRAM_RW_32_tb_1: ECE_224A_final/SRAM_write_tb/schematic, simulator hspiceD
    Variables: vddi = 1
    Outputs: /vss; /pchb; /wl; /bl; /blb; /sae; /I7/Q; /I7/Qb; /out_sa
