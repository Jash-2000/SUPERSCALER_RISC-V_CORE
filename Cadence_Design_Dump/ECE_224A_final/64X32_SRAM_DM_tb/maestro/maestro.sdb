ADE simulation setup
Run mode: Single Run, Sweeps and Corners
Tests:
  ECE_224A_final_64X32_SRAM_tb_1: ECE_224A_final/64X32_SRAM_DM_tb/schematic, simulator hspiceD
    Variables: vddi = 1
    Outputs: /V14/PLUS; /wr_di<0>; /wr_en; /pchb; /wl<2>; /bl<0>; /blb<0>; /vss; /I2/I8/Q; /I2/I8/Qb; /sa_en; /out_sa<0>; /addr<5:0>; /ck; /addr_en; /I5/I32/Q; /I5/I32/Qb
