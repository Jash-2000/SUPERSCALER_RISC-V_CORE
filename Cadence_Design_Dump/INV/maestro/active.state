ADE simulation setup
Test Test_INV_1: Test/INV/schematic, simulator hspiceD
  Models: /fs/student/parthkulkarni/ncsu45_cp/hspice_ff.include, /fs/student/parthkulkarni/ncsu45_cp/hspice_nom.include, /fs/student/parthkulkarni/ncsu45_cp/hspice_ss.include
  Analysis dc: sweep Q_dc start=0 stop=1.8
