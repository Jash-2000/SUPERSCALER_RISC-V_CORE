ADE simulation setup
Run mode: Single Run, Sweeps and Corners
Tests:
  Full_Custom_Flow_Vsource_bit_1: Full_Custom_Flow/Vsource_bit/schematic, simulator hspiceD
    Variables: vddi = 1
    Outputs: /VOUT0; /VOUT1; /VOUT2; /VOUT3; /VOUT4; /VOUT5; /VOUT6
