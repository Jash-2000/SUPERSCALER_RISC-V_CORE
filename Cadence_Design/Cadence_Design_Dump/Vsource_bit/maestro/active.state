ADE simulation setup
Test Full_Custom_Flow_Vsource_bit_1: Full_Custom_Flow/Vsource_bit/schematic, simulator hspiceD
  Models: /fs/student/oindrila_chatterjee/ECE_224A/ncsu45_cp/hspice_nom.include
  Variables: vddi = 1
  Analysis tran: start=0 stop=100n step=10p
  Signals: /VOUT0, /VOUT1, /VOUT2, /VOUT3, /VOUT4, /VOUT5, /VOUT6
