ADE simulation setup
Test ECE_224A_final_64X32_SRAM_tb_1: ECE_224A_final/64X32_SRAM_DM_tb/schematic, simulator hspiceD
  Models: /fs/student/oindrila_chatterjee/ECE_224A/ncsu45_cp/hspice_nom.include
  Variables: vddi = 1
  Initial conditions: /I5/I32/Q = vddi; /I5/I32/Qb = 0; /blb<0> = 0; /out_sa<0> = vddi; /bl<0> = vddi
  Analysis tran: start=0 stop=200n step=10p
  Signals: /wr_di<0>, /wr_en, /pchb, /wl<2>, /bl<0>, /blb<0>, /I5/I32/Q, /I5/I32/Qb, /sa_en, /out_sa<0>, /addr<5:0>, /ck, /addr_en
