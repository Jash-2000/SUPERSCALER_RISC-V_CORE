ADE simulation setup
Test ECE_224A_REF_tb_tb_SRAM_WRITE_1: ECE_224A_REF_tb/tb_SRAM_WRITE/schematic, simulator hspiceD
  Models: /fs/student/oindrila_chatterjee/ECE_224A/ncsu45_cp/hspice_nom.include
  Variables: vddi = 1
  Initial conditions: /I6/Q = 0; /I6/Qb = vddi
  Analysis tran: start=0 stop=40n step=10p
  Signals: /wr_en, /wr_di, /bl, /blb, /wl, /I6/Q, /I6/Qb
