ADE simulation setup
Test ECE_224A_REF_tb_tb_SRAM_array_1: ECE_224A_REF_tb/tb_SRAM_array/schematic, simulator hspiceD
  Models: /fs/student/oindrila_chatterjee/ECE_224A/ncsu45_cp/hspice_nom.include
  Variables: vddi = 1
  Initial conditions: /I13/I32/Q = vddi; /I13/I32/Qb = 0; /blb<0> = 0; /bl<0> = vddi; /out_sa<0> = vddi
  Analysis tran: start=0 stop=200n step=10p
  Signals: /wr_di<0>, /wr_en, /pchb, /wl<2>, /bl<0>, /blb<0>, /I13/I32/Q, /I13/I32/Qb, /sa_en, /out_sa<0>, /addr<1:0>, /ck, /addr_en
Run mode: Single Run, Sweeps and Corners
