ADE simulation setup
Run mode: Single Run, Sweeps and Corners
Tests:
  ECE_224A_REF_tb_tb_SRAM_array_1: ECE_224A_REF_tb/tb_SRAM_array/schematic, simulator hspiceD
    Variables: vddi = 1
    Outputs: /[[[; /out_sa<2>; /I6/I0/Q; /I6/I0/Qb; "/X"; /I1/I0/Qb; /X; /I1/I0/Q; /I1/I2/Q; /I1/I2/Qb; /wr_di<0>; /wr_en; /pchb; /wl<0>; /wl<2>; /bl<0>; /blb<0>; /I10/I8/Q; /I10/I8/Qb; /sa_en; /out_sa<0>; /addr<1:0>; /ck; /addr_en; /I13/I8/Q; /I13/I8/Qb; /I13/I2/Q; /I13/I2/Qb; /I13/I32/Q; /I13/I32/Qb
