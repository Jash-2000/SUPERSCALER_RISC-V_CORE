ADE simulation setup
Run mode: Single Run, Sweeps and Corners
Tests:
  ECE_224A_REF_LP_SRAM_8T_1: ECE_224A_REF/LP_SRAM_8T/schematic, simulator hspiceD
    Variables: Q = 1; wp = {From/To}Linear:90n:10n:360n{From/To}
    Outputs: /Q; /Qb
