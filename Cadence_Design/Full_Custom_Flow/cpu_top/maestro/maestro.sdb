ADE simulation setup
Run mode: Single Run, Sweeps and Corners
Tests:
  Full_Custom_Flow_Single_Cycle_Top_1: Full_Custom_Flow/Single_Cycle_Top/schematic, simulator hspiceD
    Outputs: /net15<0:31>
