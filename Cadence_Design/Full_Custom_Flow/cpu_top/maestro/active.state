ADE simulation setup
Test Full_Custom_Flow_Single_Cycle_Top_1: Full_Custom_Flow/Single_Cycle_Top/schematic, simulator hspiceD
  Models: /fs/student/jashshah/Desktop/Cadence_Design/hspice_nom.include
  Analysis tran: start=0 stop=100n step=10p
  Signals: /net15<0:31>
Run mode: Single Run, Sweeps and Corners
