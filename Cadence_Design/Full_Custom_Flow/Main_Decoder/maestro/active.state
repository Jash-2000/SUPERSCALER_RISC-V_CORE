ADE simulation setup
Test Full_Custom_Flow_Main_Decoder_1: Full_Custom_Flow/Main_Decoder/schematic, simulator hspiceD
  Models: /fs/student/jashshah/Desktop/Cadence_Design/hspice_nom.include
  Analysis tran: start=0 stop=100n step=10p
  Signals: /I0/I4/I1/jash
