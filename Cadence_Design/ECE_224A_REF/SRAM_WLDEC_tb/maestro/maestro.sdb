ADE simulation setup
Run mode: Single Run, Sweeps and Corners
Tests:
  ECE_224A_final_SRAM_WLDEC_tb_1: ECE_224A_final/SRAM_WLDEC_tb/schematic, simulator hspiceD
    Variables: vddi = 1
    Outputs: /ck; /addr_en; /wl<0:63>; /addr<5:0>
