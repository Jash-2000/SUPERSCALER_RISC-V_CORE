ADE simulation setup
Test ECE_224A_final_SRAM_RW_32_tb_1: ECE_224A_final/SRAM_write_tb/schematic, simulator hspiceD
  Models: /fs/student/oindrila_chatterjee/ECE_224A/ncsu45_cp/hspice_nom.include
  Variables: vddi = 1
  Analysis tran: start=0 stop=40n step=10p
  Signals: /pchb, /wl, /bl, /blb, /sae, /I7/Q, /I7/Qb, /out_sa
