ADE simulation setup
Test Test_Bench_ALU_Reduced_Block_1: Test_Bench/ALU_Reduced_Block/schematic, simulator hspiceD
  Models: /fs/student/jashshah/Desktop/Cadence/hspice_nom.include
  Analysis tran: start=0 stop=100n step=10n
  Signals: /A<0:3>, /B<0:3>, /AC<3:0>, /Result<0:3>
Run mode: Single Run, Sweeps and Corners
