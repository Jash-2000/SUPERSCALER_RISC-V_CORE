ADE simulation setup
Run mode: Single Run, Sweeps and Corners
Tests:
  Test_Bench_ALU_Reduced_Block_1: Test_Bench/ALU_Reduced_Block/schematic, simulator hspiceD
    Outputs: /A<0:3>; /B<0:3>; /AC<3:0>; /Result<0:3>
