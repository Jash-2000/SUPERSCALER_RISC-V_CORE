ADE simulation setup
Test Test_Bench_FullAdder_1: Test_Bench/FullAdder/schematic, simulator hspiceD
  Models: /fs/student/jashshah/Desktop/Cadence/hspice_nom.include
  Initial conditions: /Cin = 0
  Analysis tran: start=0 stop=100n step=10n
  Signals: /A, /B, /SUM, /Cout, /Cin
Run mode: Single Run, Sweeps and Corners
