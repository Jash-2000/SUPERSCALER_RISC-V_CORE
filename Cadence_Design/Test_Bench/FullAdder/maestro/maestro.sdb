ADE simulation setup
Run mode: Single Run, Sweeps and Corners
Tests:
  Test_Bench_FullAdder_1: Test_Bench/FullAdder/schematic, simulator hspiceD
    Outputs: /A; /B; /SUM; /Cout; /Cin
