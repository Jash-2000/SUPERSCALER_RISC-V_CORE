ADE simulation setup
Run mode: Single Run, Sweeps and Corners
Tests:
  Test_Bench_ALU_Block_1: Test_Bench/ALU_Block/schematic, simulator hspiceD
    Outputs: /A<31:0>; /B<31:0>; IsEqual; LessThan; /Rshift<31>; /Rshift<0>; /ARshift<31>; /ARshift<0>
