ADE simulation setup
Test Test_Bench_ALU_Block_1: Test_Bench/ALU_Block/schematic, simulator hspiceD
  Models: /fs/student/jashshah/Desktop/Cadence/hspice_nom.include
  Analysis tran: start=0 stop=100n step=10n
  Signals: /A<31:0>, /B<31:0>, /net4 as IsEqual, /RTL_LT as LessThan, /Rshift<31>, /Rshift<0>, /ARshift<31>, /ARshift<0>
Run mode: Single Run, Sweeps and Corners
