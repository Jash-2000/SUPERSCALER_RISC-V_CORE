ADE simulation setup
Test Test_Bench_cpu_top_tb_1: Test_Bench/cpu_top_tb/schematic, simulator hspiceD
  Models: /fs/student/jashshah/Desktop/Cadence/hspice_nom.include
  Analysis tran: start=0 stop=100n step=10n
  Signals: /clk, /pchb_dmem, /pchb_instr
Run mode: Single Run, Sweeps and Corners
