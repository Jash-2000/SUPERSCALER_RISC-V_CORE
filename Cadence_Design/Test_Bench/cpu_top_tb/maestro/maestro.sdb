ADE simulation setup
Run mode: Single Run, Sweeps and Corners
Tests:
  Test_Bench_cpu_top_tb_1: Test_Bench/cpu_top_tb/schematic, simulator hspiceD
    Outputs: /clk; /pchb_dmem; /pchb_instr
