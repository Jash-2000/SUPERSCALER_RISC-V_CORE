ADE simulation setup
Run mode: Single Run, Sweeps and Corners
Tests:
  Test_Bench_PC_Unit_1: Test_Bench/PC_Unit/schematic, simulator hspiceD
    Outputs: /clk; /Imm<31:0>; /PCSrc; /PC<31:0>; /PCplus4<31:0>; /reset; /Cout
