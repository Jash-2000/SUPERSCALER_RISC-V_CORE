ADE simulation setup
Test Test_Bench_PC_Unit_1: Test_Bench/PC_Unit/schematic, simulator hspiceD
  Models: /fs/student/jashshah/Desktop/Cadence/hspice_nom.include
  Initial conditions: /net3<0:31> = 0; /Cout = 0; /PCplus4<31:0> = 0; /PC<31:0> = 0
  Analysis tran: start=0 stop=100n step=10n
  Signals: /clk, /Imm<31:0>, /PCSrc, /PC<31:0>, /PCplus4<31:0>, /reset, /Cout
Run mode: Single Run, Sweeps and Corners
