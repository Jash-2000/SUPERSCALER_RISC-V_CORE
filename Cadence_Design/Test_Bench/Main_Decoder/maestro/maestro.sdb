ADE simulation setup
Run mode: Single Run, Sweeps and Corners
Tests:
  Test_Bench_Main_Decoder_1: Test_Bench/Main_Decoder/schematic, simulator hspiceD
    Outputs: /op<6:0>; /control_signals<5:4>; /control_signals<10>; /control_signals<6>; /control_signals<0>; /control_signals<9:8>; /control_signals<3>; /control_signals<2:1>; /control_signals<7>
