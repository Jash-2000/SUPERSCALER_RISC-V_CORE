ADE simulation setup
Run mode: Single Run, Sweeps and Corners
Tests:
  Test_Bench_PC_Block_1: Test_Bench/PC_Block/schematic, simulator hspiceD
    Outputs: /PC<31:0>; /pcn<31:0>; /clk; /reset; /resetB
