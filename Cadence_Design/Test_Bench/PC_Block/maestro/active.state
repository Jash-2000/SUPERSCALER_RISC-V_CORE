ADE simulation setup
Test Test_Bench_PC_Block_1: Test_Bench/PC_Block/schematic, simulator hspiceD
  Models: /fs/student/jashshah/Desktop/Cadence/hspice_nom.include
  Analysis tran: start=0 stop=100n step=10n
  Signals: /PC<31:0>, /pcn<31:0>, /clk, /resetB
Run mode: Single Run, Sweeps and Corners
