ADE simulation setup
Test Test_FullAdder_1: Test/FullAdder/schematic, simulator hspiceD
  Models: /fs/student/jashshah/Desktop/Cadence_Design/hspice_nom.include
  Analysis tran: start=0 stop=100n step=10n
  Signals: /SUM, /Cout
Run mode: Single Run, Sweeps and Corners
