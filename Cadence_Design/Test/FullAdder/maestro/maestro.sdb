ADE simulation setup
Run mode: Single Run, Sweeps and Corners
Tests:
  Test_FullAdder_1: Test/FullAdder/schematic, simulator hspiceD
    Outputs: /SUM; /Cout
