;;-----------------------------------------------------------------------------
;; Bindkeys for 'Layout'
;; Inherited by:
;;             * Dracula Interactive
;;             * NC-Verilog-MaskLayout
;;             * Other-Layout
;;             * Other-MaskLayout
;;             * Other-Symbolic
;;             * Pcell
;;             * Power IR/EM
;;             * Spectre-Layout
;;             * Spectre-MaskLayout
;;             * Spectre-Symbolic
;;             * UltraSim-Layout
;;             * UltraSim-MaskLayout
;;             * UltraSim-Symbolic
;;             * VLS-GXL
;;             * Virtuoso CE
;;             * Virtuoso XL
;;             * adegxl-maskLayout
;;             * adexl-maskLayout
;;             * parasitics-MaskLayout
;;             * sip-layout
;;-----------------------------------------------------------------------------
hiSetBindKeys( "Layout" list(
    list("<DrawThru1>"	"leSelBoxOrStretch()"	"geSingleSelectBox()")
    list("<DrawThru2>"	""	"_cmdOptionDrawThru2()")
    list("<DrawThru3>"	"hiZoomIn()"	"hiZoomIn()")
    list("<Key>!"	"_leCreateQuickFigGroup(getCurrentWindow())")
    list("<Key>#"	"_pteHiLayerSetNoneVisible(dwindow('pteLayerPalette1))")
    list("<Key>$"	"_pteHiLayerSetAllVisible(dwindow('pteLayerPalette1))")
    list("<Key>%"	"leHiMarkNet()")
    list("<Key>'"	"hiUpdateMagOptions()")
    list("<Key>."	"leToggleMagnifier()")
    list("<Key>1"	"hiGetCurrentWindow()->stopLevel = 1"	"drdEnablePixelThreshold(!drdIsPixelThresholdEnabled())")
    list("<Key>2"	"hiGetCurrentWindow()->stopLevel = 2")
    list("<Key>3"	"hiGetCurrentWindow()->stopLevel = 3")
    list("<Key>4"	"hiGetCurrentWindow()->stopLevel = 4")
    list("<Key>5"	"hiGetCurrentWindow()->stopLevel = 5")
    list("<Key>6"	"hiGetCurrentWindow()->stopLevel = 6")
    list("<Key>7"	"hiGetCurrentWindow()->stopLevel = 7")
    list("<Key>8"	"hiGetCurrentWindow()->stopLevel = 8")
    list("<Key>9"	"hiGetCurrentWindow()->stopLevel = 9")
    list("<Key>@"	"leHiUngroup()")
    list("<Key>A"	"geSingleSelectPoint()")
    list("<Key>B"	"geReturnToLevel()")
    list("<Key>BackSpace"	"deletePoint()"	"deletePoint()")
    list("<Key>C"	"leHiCopy()")
    list("<Key>D"	"geSubSelectPoint()")
    list("<Key>Delete"	"leHiDelete()"	"leHiDelete()")
    list("<Key>Down"	"geScroll(nil \"s\"	nil)")
    list("<Key>E"	"leHiEditDisplayOptions()")
    list("<Key>Escape"	""	"cancelEnterFun()")
    list("<Key>F"	"hiZoomAbsoluteScale(hiGetCurrentWindow() 0.9)")
    list("<Key>F1"	"hiHelp('window deGetAppInfo(deGetEditViewType(hiGetCurrentWindow()))->appName)")
    list("<Key>F11"	"deToggleAssistants()")
    list("<Key>F2"	"geSave()")
    list("<Key>F3"	"geSaveAs()"	"hiToggleEnterForm()")
    list("<Key>F4"	"geTogglePartialSelect()")
    list("<Key>F5"	"deOpen()")
    list("<Key>F6"	"hiRedraw()")
    list("<Key>F7"	"leHiEditDRDRuleOptions()")
    list("<Key>F9"	"geToggleFilterSize()")
    list("<Key>G"	"leHiQuickAlign()")
    list("<Key>H"	"leHiRepeatCopy()")
    list("<Key>I"	"leHiCreateInst()")
    list("<Key>J"	"geSelObjectsPartiallySelected()")
    list("<Key>K"	"leHiCreateRuler()")
    list("<Key>KP_Add"	"leHiSetRefPoint()")
    list("<Key>KP_Divide"	"legRpDelta = 1.0"	"drdAddTarget()")
    list("<Key>KP_Enter"	"mouseAddPt()")
    list("<Key>KP_Equal"	"legRpDelta = 0.5")
    list("<Key>KP_Multiply"	"legRpDelta = 2.0"	"drdRemoveTarget()")
    list("<Key>KP_Subtract"	"leSetRefPointInactive(geGetEditCellView())")
    list("<Key>L"	"leHiCreateLabel()")
    list("<Key>Left"	"geScroll(nil \"w\"	nil)")
    list("<Key>M"	"leHiMove()")
    list("<Key>N"	"leSetFormSnapMode(\"diagonal\")")
    list("<Key>O"	"leHiCreateVia()")
    list("<Key>P"	"leHiCreatePath()")
    list("<Key>Q"	"leHiEditProp()")
    list("<Key>R"	"leHiCreateRect()")
    list("<Key>R11"	"geScroll(nil \"\"	nil)")
    list("<Key>R13"	"geScroll(nil \"sw\"	nil)")
    list("<Key>R15"	"geScroll(nil \"se\"	nil)")
    list("<Key>R4"	"legRpDelta = 0.5")
    list("<Key>R5"	"legRpDelta = 1.0")
    list("<Key>R6"	"legRpDelta = 2.0")
    list("<Key>R7"	"geScroll(nil \"nw\"	nil)")
    list("<Key>R9"	"geScroll(nil \"ne\"	nil)")
    list("<Key>Right"	"geScroll(nil \"e\"	nil)")
    list("<Key>S"	"leHiStretch()")
    list("<Key>T"	"leHiLayerTap()")
    list("<Key>Tab"	"hiPan()")
    list("<Key>U"	"hiUndo()")
    list("<Key>Up"	"geScroll(nil \"n\"	nil)")
    list("<Key>V"	"leHiAttach()")
    list("<Key>W"	"hiPrevWinView(hiGetCurrentWindow())")
    list("<Key>X"	"leHiEditInPlace()")
    list("<Key>Y"	"leHiYank()")
    list("<Key>Z"	"hiZoomIn()")
    list("<Key>^"	"_leUnmarkNetAllCB()")
    list("<Key>`"	"hiGetCurrentWindow()->stopLevel = 0"	"drdToggleSmartSnapMode()")
    list("<Key>space"	"hiRedraw()"	"leSpaceBarFunc(hiGetCurrentWindow() t)")
    list("Ctrl Shift<Btn1Down>"	"hiZoomInMagnifier(hiGetCurrentWindow())")
    list("Ctrl Shift<Btn2Down>"	"hiZoomOutMagnifier(hiGetCurrentWindow())")
    list("Ctrl Shift<Btn4Down>"	"_leWireCmdMagnifierOrIncreaseWidth()")
    list("Ctrl Shift<Btn5Down>"	"_leWireCmdMagnifierOrDecreaseWidth()")
    list("Ctrl Shift<Key>A"	"leHiAddWireVia(hiGetCurrentWindow() \"down\")")
    list("Ctrl Shift<Key>D"	"leHiP2P()")
    list("Ctrl Shift<Key>Down"	"hiScaleMagnifier(0.80)")
    list("Ctrl Shift<Key>F"	"leFinishEntireNet()")
    list("Ctrl Shift<Key>G"	"_weGatherBusWires(hiGetCurrentWindow() not(_weIsGatheringBusWires(hiGetCurrentWindow())))")
    list("Ctrl Shift<Key>H"	"drdCompactSelSet('left)")
    list("Ctrl Shift<Key>J"	"drdCompactSelSet('right)")
    list("Ctrl Shift<Key>K"	"leHiClearRulerInHier()")
    list("Ctrl Shift<Key>N"	"drdCompactSelSet('bottom)")
    list("Ctrl Shift<Key>Q"	"leHiAddWireVia(hiGetCurrentWindow() \"up\")")
    list("Ctrl Shift<Key>R"	"leHiCreateRoute()")
    list("Ctrl Shift<Key>S"	"leHiGuidedRouting()")
    list("Ctrl Shift<Key>T"	"drdCompactSelSet('target)")
    list("Ctrl Shift<Key>U"	"drdCompactSelSet('top)")
    list("Ctrl Shift<Key>Up"	"hiScaleMagnifier(1.25)")
    list("Ctrl Shift<Key>V"	"leFinishWire()")
    list("Ctrl Shift<Key>W"	"leHiCreateWire()")
    list("Ctrl Shift<Key>X"	"leHiCreateBus()")
    list("Ctrl Shift<Key>Z"	"leWECycleControlWire()")
    list("Ctrl Shift<Key>space"	"(leWENoSnap)"	"leSpaceBarFunc(hiGetCurrentWindow() \"ctrlShift\")")
    list("Ctrl<Btn1Down>"	"mouseSubSelectPt()"	"mouseSubSelectPt()")
    list("Ctrl<Btn2Down>"	""	"cmdCtrlOption()")
    list("Ctrl<Btn4Down>"	"hiZoomInAtMouse()")
    list("Ctrl<Btn5Down>"	"hiZoomOutAtMouse()")
    list("Ctrl<DrawThru1>"	"geSubSelectBox()"	"geSubSelectBox()")
    list("Ctrl<Key>1"	"mgc_custom_menus_run_menu_cmd(\"DRC\" \"::CalibreInterface::execCalibre DRC\" 'nil ?code \"\")")
    list("Ctrl<Key>2"	"mgc_custom_menus_run_menu_cmd(\"LVS\" \"::CalibreInterface::execCalibre LVS\" 'nil ?code \"\")")
    list("Ctrl<Key>3"	"mgc_custom_menus_run_menu_cmd(\"PEX\" \"::CalibreInterface::execCalibre PEX\" 'nil ?code \"\")")
    list("Ctrl<Key>4"	"tsmcPdkGuardRing()")
    list("Ctrl<Key>6"	"leHiUnmarkNet()")
    list("Ctrl<Key>A"	"geSelectAllFig()")
    list("Ctrl<Key>B"	"leReturn()")
    list("Ctrl<Key>C"	"mgc_rve_end_enter_function_binding(\"Layout\")")
    list("Ctrl<Key>D"	"_leRotateOrFlip(\"MX\")")
    list("Ctrl<Key>Down"	"geScroll(nil \"s\"	t)")
    list("Ctrl<Key>E"	"leHiFlatten()")
    list("Ctrl<Key>F"	"hiGetCurrentWindow()->stopLevel = 0")
    list("Ctrl<Key>F11"	"deToggleToolbars()")
    list("Ctrl<Key>G"	"geZoomToGrid(hiGetCurrentWindow())")
    list("Ctrl<Key>H"	"geDSAFreeze(hiGetCurrentWindow()  hiGetPoint(hiGetCurrentWindow()))")
    list("Ctrl<Key>I"	"leBalloonCycleThru()")
    list("Ctrl<Key>J"	"leHiFlip()")
    list("Ctrl<Key>K"	"leToggleKeepFirstName()")
    list("Ctrl<Key>Left"	"geScroll(nil \"w\"	t)")
    list("Ctrl<Key>N"	"leSetFormSnapMode(\"L90XFirst\")")
    list("Ctrl<Key>O"	"geSelectViaPile()")
    list("Ctrl<Key>P"	"leHiCreatePin()")
    list("Ctrl<Key>Q"	"_leRotateOrFlip(\"R90\")")
    list("Ctrl<Key>R"	"hiRedraw()")
    list("Ctrl<Key>R11"	"geScroll(nil \"\"	t)")
    list("Ctrl<Key>R13"	"geScroll(nil \"sw\"	t)")
    list("Ctrl<Key>R15"	"geScroll(nil \"se\"	t)")
    list("Ctrl<Key>R7"	"geScroll(nil \"nw\"	t)")
    list("Ctrl<Key>R9"	"geScroll(nil \"ne\"	t)")
    list("Ctrl<Key>Right"	"geScroll(nil \"e\"	t)")
    list("Ctrl<Key>S"	"leHiSplit()")
    list("Ctrl<Key>T"	"leZoomToSelSet()")
    list("Ctrl<Key>Tab"	"hiLowerWindow(hiGetCurrentWindow())")
    list("Ctrl<Key>Up"	"geScroll(nil \"n\"	t)")
    list("Ctrl<Key>V"	"hiFocusToCIW(hiGetCurrentWindow())")
    list("Ctrl<Key>W"	"leCloseWindow()")
    list("Ctrl<Key>X"	"leEIPZoomAbsoluteScale(hiGetCurrentWindow() 0.9)")
    list("Ctrl<Key>Y"	"geCycleSelectNext()")
    list("Ctrl<Key>Z"	"hiZoomRelativeScale(hiGetCurrentWindow() 2.0)")
    list("Ctrl<Key>space"	"(leWECycleSnap)"	"leSpaceBarFunc(hiGetCurrentWindow() \"cancel\")")
    list("None<Btn1Down>"	"mouseSingleSelectPt() _leiLMBPress() _leiLMBPress()"	"mouseAddPt(t)")
    list("None<Btn1Down>(2)"	"leDoubleClick()"	"mouseApplyOrFinishPoint()")
    list("None<Btn2Down>"	"hiRepeat()"	"cmdOption()")
    list("None<Btn3Down>"	"_lxHiMousePopUp()"	"_lxHiMousePopUp()")
    list("None<Btn3Down>(2)"	"leHiEditProp()"	"hiToggleEnterForm()")
    list("None<Btn4Down>"	"geScroll(nil \"n\" nil)")
    list("None<Btn5Down>"	"geScroll(nil \"s\" nil)")
    list("Return"	""	"mouseApplyOrFinishPoint()")
    list("Shift<Btn1Down>"	"mouseAddSelectPt()"	"mouseAddSelectPt()")
    list("Shift<Btn2Down>"	""	"cmdShiftOption()")
    list("Shift<Btn4Down>"	"geScroll(nil \"w\" nil)")
    list("Shift<Btn5Down>"	"geScroll(nil \"e\" nil)")
    list("Shift<DrawThru1>"	"geAddSelectBox()"	"geAddSelectBox()")
    list("Shift<DrawThru3>"	"hiZoomOut()"	"hiZoomOut()")
    list("Shift<Key>A"	"leAlign(\"left\")")
    list("Shift<Key>B"	"geReturn()")
    list("Shift<Key>C"	"leHiChop()")
    list("Shift<Key>D"	"_leRotateOrFlip(\"MY\")")
    list("Shift<Key>Down"	"leMoveCursor(0           -legRpDelta)")
    list("Shift<Key>E"	"leHiEditEditorOptions()")
    list("Shift<Key>F"	"hiGetCurrentWindow()->stopLevel = dbGetMaxHierDepth()")
    list("Shift<Key>F11"	"deToggleToolbars() deToggleAssistants()")
    list("Shift<Key>F4"	"geToggleAreaSelectOption()")
    list("Shift<Key>F5"	"leFullSelectFigOfSelSet()")
    list("Shift<Key>G"	"leAlign(\"horizontal\")")
    list("Shift<Key>I"	"leHiGuidedRoutingReverseEnvelope(hiGetCurrentWindow())")
    list("Shift<Key>K"	"leHiClearRuler()")
    list("Shift<Key>L"	"geChangeCellView()")
    list("Shift<Key>Left"	"leMoveCursor(-legRpDelta           0)")
    list("Shift<Key>M"	"leHiMerge()")
    list("Shift<Key>N"	"leSetFormSnapMode(\"orthogonal\")")
    list("Shift<Key>O"	"leHiEditEditorOptions()")
    list("Shift<Key>P"	"leHiCreatePolygon()")
    list("Shift<Key>Q"	"leAlign(\"vertical\")")
    list("Shift<Key>R"	"leHiReShape()")
    list("Shift<Key>R11"	"leMoveCursorToRefPoint()")
    list("Shift<Key>R13"	"leMoveCursor(-legRpDelta -legRpDelta)")
    list("Shift<Key>R15"	"leMoveCursor( legRpDelta -legRpDelta)")
    list("Shift<Key>R7"	"leMoveCursor(-legRpDelta  legRpDelta)")
    list("Shift<Key>R9"	"leMoveCursor( legRpDelta  legRpDelta)")
    list("Shift<Key>Right"	"leMoveCursor( legRpDelta           0)")
    list("Shift<Key>S"	"leAlign(\"right\")")
    list("Shift<Key>T"	"leAlign(\"top\")")
    list("Shift<Key>U"	"hiRedo()")
    list("Shift<Key>Up"	"leMoveCursor(          0  legRpDelta)")
    list("Shift<Key>V"	"leAlign(\"bottom\")")
    list("Shift<Key>W"	"hiNextWinView(hiGetCurrentWindow())")
    list("Shift<Key>X"	"leHiDescend()")
    list("Shift<Key>Y"	"leHiPaste()")
    list("Shift<Key>Z"	"hiZoomRelativeScale(hiGetCurrentWindow() 0.5)")
    list("Shift<Key>space"	""	"leSpaceBarFunc(hiGetCurrentWindow() t t)")

    ;; Empty bindkeys (typically inserted when a bindkey is redefined or deleted)
    list("Ctrl<Key>5"	"")
    list("Shift<Key>."	"")
)) ;; hiSetBindKeys
;;-----------------------------------------------------------------------------
